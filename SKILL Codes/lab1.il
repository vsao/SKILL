pcDefinePCell(
   list( ddGetObj("test") "pcell" "layout")
   list((w 0.2) (l 0.1))
   let( (cv)
      cv=pcCellView
      dbCreateRect(cv list("MET1" "drawing") list(0:0 w:l))
   ) ;let
) ;pcDefineCell
