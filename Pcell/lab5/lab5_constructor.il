procedure( CCScreatePcell5(cv w l layer)
   let( ()
      dbCreateRect(cv list(layer "drawing") list(0:0 w:l))
   ) ;let
) ;procedure
