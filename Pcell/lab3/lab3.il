pcDefinePCell(
	list(ddGetObj("TestSkill") "pcell3" "layout")
	list((w 0.2) (l 0.1) (layer "MET1"))
	let((cv)
	     cv=pcCellView
	     CCScreatePcell3(cv w l layer)
	   )
)
